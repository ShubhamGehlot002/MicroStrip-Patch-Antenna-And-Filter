# Ansys Electronics Desktop project, version 2023.2

design Circuit1 (Circuit)
options: SParamCircuitDef IntegrationMethod=FFT
components:
  A1 = NXCPLE(ZE=118.9ohm ZO=50.9ohm E=90deg F=1.5GHz)
  A2 = TRLE_NX(Z=113 E=180deg F=1.5GHz)
  A3 = NXOSTE(F=1.5GHz Z=48ohm)
  A5 = NXOSTE(Z=48ohm F=1.5GHz)
  port Port1 rz=50ohm iz=0ohm EnableNoise=false noisetemp=16.85cel
  port Port2 rz=50ohm iz=0ohm EnableNoise=false noisetemp=16.85cel
nets:
  Port1: A1.0, A2.0, A5.0
  Port2: A1.1, A3.0, A2.1
setups:
  LinearFrequency2: LinearFrequencyData(false, 0.1, false, "", false) SweepDefinition{Variable=Freq Data="LIN 0GHz 6GHz 0.001GHz"}
reports:
  S Parameter Plot 1: dB(S(Port1,Port1)), dB(S(Port2,Port1)) vs Freq on LinearFrequency2 : LinearFrequency2
  S Parameter Plot 2: S(Port1,Port1), S(Port2,Port1) on LinearFrequency2 : LinearFrequency2 [Freq=all]
